* Empty subcircuit for efpga_subsystem_top (blackbox view for LVS)
.SUBCKT efpga_subsystem_top
+ VDD VSS clk_i rst_efpga_connector_n_i rst_efpga_connector_i rst_efpga_fabric_n_i
+ rst_efpga_slot_n_i[0] rst_efpga_slot_n_i[1] rst_efpga_slot_n_i[2] rst_efpga_slot_n_i[3]
+ rst_efpga_npu_n_i s_axil_mgr_awaddr[0] s_axil_mgr_awaddr[1] s_axil_mgr_awaddr[2]
+ s_axil_mgr_awaddr[3] s_axil_mgr_awaddr[4] s_axil_mgr_awaddr[5] s_axil_mgr_awaddr[6]
+ s_axil_mgr_awaddr[7] s_axil_mgr_awaddr[8] s_axil_mgr_awaddr[9] s_axil_mgr_awaddr[10]
+ s_axil_mgr_awaddr[11] s_axil_mgr_awaddr[12] s_axil_mgr_awaddr[13] s_axil_mgr_awaddr[14]
+ s_axil_mgr_awaddr[15] s_axil_mgr_awaddr[16] s_axil_mgr_awaddr[17] s_axil_mgr_awaddr[18]
+ s_axil_mgr_awaddr[19] s_axil_mgr_awaddr[20] s_axil_mgr_awaddr[21] s_axil_mgr_awaddr[22]
+ s_axil_mgr_awaddr[23] s_axil_mgr_awaddr[24] s_axil_mgr_awaddr[25] s_axil_mgr_awaddr[26]
+ s_axil_mgr_awaddr[27] s_axil_mgr_awaddr[28] s_axil_mgr_awaddr[29] s_axil_mgr_awaddr[30]
+ s_axil_mgr_awaddr[31] s_axil_mgr_awprot[0] s_axil_mgr_awprot[1] s_axil_mgr_awprot[2]
+ s_axil_mgr_awvalid s_axil_mgr_awready s_axil_mgr_wdata[0] s_axil_mgr_wdata[1] s_axil_mgr_wdata[2]
+ s_axil_mgr_wdata[3] s_axil_mgr_wdata[4] s_axil_mgr_wdata[5] s_axil_mgr_wdata[6]
+ s_axil_mgr_wdata[7] s_axil_mgr_wdata[8] s_axil_mgr_wdata[9] s_axil_mgr_wdata[10]
+ s_axil_mgr_wdata[11] s_axil_mgr_wdata[12] s_axil_mgr_wdata[13] s_axil_mgr_wdata[14]
+ s_axil_mgr_wdata[15] s_axil_mgr_wdata[16] s_axil_mgr_wdata[17] s_axil_mgr_wdata[18]
+ s_axil_mgr_wdata[19] s_axil_mgr_wdata[20] s_axil_mgr_wdata[21] s_axil_mgr_wdata[22]
+ s_axil_mgr_wdata[23] s_axil_mgr_wdata[24] s_axil_mgr_wdata[25] s_axil_mgr_wdata[26]
+ s_axil_mgr_wdata[27] s_axil_mgr_wdata[28] s_axil_mgr_wdata[29] s_axil_mgr_wdata[30]
+ s_axil_mgr_wdata[31] s_axil_mgr_wstrb[0] s_axil_mgr_wstrb[1] s_axil_mgr_wstrb[2]
+ s_axil_mgr_wstrb[3] s_axil_mgr_wvalid s_axil_mgr_wready s_axil_mgr_bresp[0] s_axil_mgr_bresp[1]
+ s_axil_mgr_bvalid s_axil_mgr_bready s_axil_mgr_araddr[0] s_axil_mgr_araddr[1] s_axil_mgr_araddr[2]
+ s_axil_mgr_araddr[3] s_axil_mgr_araddr[4] s_axil_mgr_araddr[5] s_axil_mgr_araddr[6]
+ s_axil_mgr_araddr[7] s_axil_mgr_araddr[8] s_axil_mgr_araddr[9] s_axil_mgr_araddr[10]
+ s_axil_mgr_araddr[11] s_axil_mgr_araddr[12] s_axil_mgr_araddr[13] s_axil_mgr_araddr[14]
+ s_axil_mgr_araddr[15] s_axil_mgr_araddr[16] s_axil_mgr_araddr[17] s_axil_mgr_araddr[18]
+ s_axil_mgr_araddr[19] s_axil_mgr_araddr[20] s_axil_mgr_araddr[21] s_axil_mgr_araddr[22]
+ s_axil_mgr_araddr[23] s_axil_mgr_araddr[24] s_axil_mgr_araddr[25] s_axil_mgr_araddr[26]
+ s_axil_mgr_araddr[27] s_axil_mgr_araddr[28] s_axil_mgr_araddr[29] s_axil_mgr_araddr[30]
+ s_axil_mgr_araddr[31] s_axil_mgr_arprot[0] s_axil_mgr_arprot[1] s_axil_mgr_arprot[2]
+ s_axil_mgr_arvalid s_axil_mgr_arready s_axil_mgr_rdata[0] s_axil_mgr_rdata[1] s_axil_mgr_rdata[2]
+ s_axil_mgr_rdata[3] s_axil_mgr_rdata[4] s_axil_mgr_rdata[5] s_axil_mgr_rdata[6]
+ s_axil_mgr_rdata[7] s_axil_mgr_rdata[8] s_axil_mgr_rdata[9] s_axil_mgr_rdata[10]
+ s_axil_mgr_rdata[11] s_axil_mgr_rdata[12] s_axil_mgr_rdata[13] s_axil_mgr_rdata[14]
+ s_axil_mgr_rdata[15] s_axil_mgr_rdata[16] s_axil_mgr_rdata[17] s_axil_mgr_rdata[18]
+ s_axil_mgr_rdata[19] s_axil_mgr_rdata[20] s_axil_mgr_rdata[21] s_axil_mgr_rdata[22]
+ s_axil_mgr_rdata[23] s_axil_mgr_rdata[24] s_axil_mgr_rdata[25] s_axil_mgr_rdata[26]
+ s_axil_mgr_rdata[27] s_axil_mgr_rdata[28] s_axil_mgr_rdata[29] s_axil_mgr_rdata[30]
+ s_axil_mgr_rdata[31] s_axil_mgr_rresp[0] s_axil_mgr_rresp[1] s_axil_mgr_rvalid s_axil_mgr_rready
+ s_axil_ctrl_awaddr[0] s_axil_ctrl_awaddr[1] s_axil_ctrl_awaddr[2] s_axil_ctrl_awaddr[3]
+ s_axil_ctrl_awaddr[4] s_axil_ctrl_awaddr[5] s_axil_ctrl_awaddr[6] s_axil_ctrl_awaddr[7]
+ s_axil_ctrl_awaddr[8] s_axil_ctrl_awaddr[9] s_axil_ctrl_awaddr[10] s_axil_ctrl_awaddr[11]
+ s_axil_ctrl_awaddr[12] s_axil_ctrl_awaddr[13] s_axil_ctrl_awaddr[14] s_axil_ctrl_awaddr[15]
+ s_axil_ctrl_awaddr[16] s_axil_ctrl_awaddr[17] s_axil_ctrl_awaddr[18] s_axil_ctrl_awaddr[19]
+ s_axil_ctrl_awaddr[20] s_axil_ctrl_awaddr[21] s_axil_ctrl_awaddr[22] s_axil_ctrl_awaddr[23]
+ s_axil_ctrl_awaddr[24] s_axil_ctrl_awaddr[25] s_axil_ctrl_awaddr[26] s_axil_ctrl_awaddr[27]
+ s_axil_ctrl_awaddr[28] s_axil_ctrl_awaddr[29] s_axil_ctrl_awaddr[30] s_axil_ctrl_awaddr[31]
+ s_axil_ctrl_awprot[0] s_axil_ctrl_awprot[1] s_axil_ctrl_awprot[2] s_axil_ctrl_awvalid
+ s_axil_ctrl_awready s_axil_ctrl_wdata[0] s_axil_ctrl_wdata[1] s_axil_ctrl_wdata[2]
+ s_axil_ctrl_wdata[3] s_axil_ctrl_wdata[4] s_axil_ctrl_wdata[5] s_axil_ctrl_wdata[6]
+ s_axil_ctrl_wdata[7] s_axil_ctrl_wdata[8] s_axil_ctrl_wdata[9] s_axil_ctrl_wdata[10]
+ s_axil_ctrl_wdata[11] s_axil_ctrl_wdata[12] s_axil_ctrl_wdata[13] s_axil_ctrl_wdata[14]
+ s_axil_ctrl_wdata[15] s_axil_ctrl_wdata[16] s_axil_ctrl_wdata[17] s_axil_ctrl_wdata[18]
+ s_axil_ctrl_wdata[19] s_axil_ctrl_wdata[20] s_axil_ctrl_wdata[21] s_axil_ctrl_wdata[22]
+ s_axil_ctrl_wdata[23] s_axil_ctrl_wdata[24] s_axil_ctrl_wdata[25] s_axil_ctrl_wdata[26]
+ s_axil_ctrl_wdata[27] s_axil_ctrl_wdata[28] s_axil_ctrl_wdata[29] s_axil_ctrl_wdata[30]
+ s_axil_ctrl_wdata[31] s_axil_ctrl_wstrb[0] s_axil_ctrl_wstrb[1] s_axil_ctrl_wstrb[2]
+ s_axil_ctrl_wstrb[3] s_axil_ctrl_wvalid s_axil_ctrl_wready s_axil_ctrl_bresp[0]
+ s_axil_ctrl_bresp[1] s_axil_ctrl_bvalid s_axil_ctrl_bready s_axil_ctrl_araddr[0]
+ s_axil_ctrl_araddr[1] s_axil_ctrl_araddr[2] s_axil_ctrl_araddr[3] s_axil_ctrl_araddr[4]
+ s_axil_ctrl_araddr[5] s_axil_ctrl_araddr[6] s_axil_ctrl_araddr[7] s_axil_ctrl_araddr[8]
+ s_axil_ctrl_araddr[9] s_axil_ctrl_araddr[10] s_axil_ctrl_araddr[11] s_axil_ctrl_araddr[12]
+ s_axil_ctrl_araddr[13] s_axil_ctrl_araddr[14] s_axil_ctrl_araddr[15] s_axil_ctrl_araddr[16]
+ s_axil_ctrl_araddr[17] s_axil_ctrl_araddr[18] s_axil_ctrl_araddr[19] s_axil_ctrl_araddr[20]
+ s_axil_ctrl_araddr[21] s_axil_ctrl_araddr[22] s_axil_ctrl_araddr[23] s_axil_ctrl_araddr[24]
+ s_axil_ctrl_araddr[25] s_axil_ctrl_araddr[26] s_axil_ctrl_araddr[27] s_axil_ctrl_araddr[28]
+ s_axil_ctrl_araddr[29] s_axil_ctrl_araddr[30] s_axil_ctrl_araddr[31] s_axil_ctrl_arprot[0]
+ s_axil_ctrl_arprot[1] s_axil_ctrl_arprot[2] s_axil_ctrl_arvalid s_axil_ctrl_arready
+ s_axil_ctrl_rdata[0] s_axil_ctrl_rdata[1] s_axil_ctrl_rdata[2] s_axil_ctrl_rdata[3]
+ s_axil_ctrl_rdata[4] s_axil_ctrl_rdata[5] s_axil_ctrl_rdata[6] s_axil_ctrl_rdata[7]
+ s_axil_ctrl_rdata[8] s_axil_ctrl_rdata[9] s_axil_ctrl_rdata[10] s_axil_ctrl_rdata[11]
+ s_axil_ctrl_rdata[12] s_axil_ctrl_rdata[13] s_axil_ctrl_rdata[14] s_axil_ctrl_rdata[15]
+ s_axil_ctrl_rdata[16] s_axil_ctrl_rdata[17] s_axil_ctrl_rdata[18] s_axil_ctrl_rdata[19]
+ s_axil_ctrl_rdata[20] s_axil_ctrl_rdata[21] s_axil_ctrl_rdata[22] s_axil_ctrl_rdata[23]
+ s_axil_ctrl_rdata[24] s_axil_ctrl_rdata[25] s_axil_ctrl_rdata[26] s_axil_ctrl_rdata[27]
+ s_axil_ctrl_rdata[28] s_axil_ctrl_rdata[29] s_axil_ctrl_rdata[30] s_axil_ctrl_rdata[31]
+ s_axil_ctrl_rresp[0] s_axil_ctrl_rresp[1] s_axil_ctrl_rvalid s_axil_ctrl_rready m_axi_dma_awid[0]
+ m_axi_dma_awid[1] m_axi_dma_awid[2] m_axi_dma_awid[3] m_axi_dma_awid[4] m_axi_dma_awid[5]
+ m_axi_dma_awid[6] m_axi_dma_awid[7] m_axi_dma_awaddr[0] m_axi_dma_awaddr[1] m_axi_dma_awaddr[2]
+ m_axi_dma_awaddr[3] m_axi_dma_awaddr[4] m_axi_dma_awaddr[5] m_axi_dma_awaddr[6]
+ m_axi_dma_awaddr[7] m_axi_dma_awaddr[8] m_axi_dma_awaddr[9] m_axi_dma_awaddr[10]
+ m_axi_dma_awaddr[11] m_axi_dma_awaddr[12] m_axi_dma_awaddr[13] m_axi_dma_awaddr[14]
+ m_axi_dma_awaddr[15] m_axi_dma_awaddr[16] m_axi_dma_awaddr[17] m_axi_dma_awaddr[18]
+ m_axi_dma_awaddr[19] m_axi_dma_awaddr[20] m_axi_dma_awaddr[21] m_axi_dma_awaddr[22]
+ m_axi_dma_awaddr[23] m_axi_dma_awaddr[24] m_axi_dma_awaddr[25] m_axi_dma_awaddr[26]
+ m_axi_dma_awaddr[27] m_axi_dma_awaddr[28] m_axi_dma_awaddr[29] m_axi_dma_awaddr[30]
+ m_axi_dma_awaddr[31] m_axi_dma_awlen[0] m_axi_dma_awlen[1] m_axi_dma_awlen[2] m_axi_dma_awlen[3]
+ m_axi_dma_awlen[4] m_axi_dma_awlen[5] m_axi_dma_awlen[6] m_axi_dma_awlen[7] m_axi_dma_awsize[0]
+ m_axi_dma_awsize[1] m_axi_dma_awsize[2] m_axi_dma_awburst[0] m_axi_dma_awburst[1] m_axi_dma_awlock
+ m_axi_dma_awcache[0] m_axi_dma_awcache[1] m_axi_dma_awcache[2] m_axi_dma_awcache[3]
+ m_axi_dma_awprot[0] m_axi_dma_awprot[1] m_axi_dma_awprot[2] m_axi_dma_awvalid m_axi_dma_awready
+ m_axi_dma_wdata[0] m_axi_dma_wdata[1] m_axi_dma_wdata[2] m_axi_dma_wdata[3] m_axi_dma_wdata[4]
+ m_axi_dma_wdata[5] m_axi_dma_wdata[6] m_axi_dma_wdata[7] m_axi_dma_wdata[8] m_axi_dma_wdata[9]
+ m_axi_dma_wdata[10] m_axi_dma_wdata[11] m_axi_dma_wdata[12] m_axi_dma_wdata[13]
+ m_axi_dma_wdata[14] m_axi_dma_wdata[15] m_axi_dma_wdata[16] m_axi_dma_wdata[17]
+ m_axi_dma_wdata[18] m_axi_dma_wdata[19] m_axi_dma_wdata[20] m_axi_dma_wdata[21]
+ m_axi_dma_wdata[22] m_axi_dma_wdata[23] m_axi_dma_wdata[24] m_axi_dma_wdata[25]
+ m_axi_dma_wdata[26] m_axi_dma_wdata[27] m_axi_dma_wdata[28] m_axi_dma_wdata[29]
+ m_axi_dma_wdata[30] m_axi_dma_wdata[31] m_axi_dma_wstrb[0] m_axi_dma_wstrb[1] m_axi_dma_wstrb[2]
+ m_axi_dma_wstrb[3] m_axi_dma_wlast m_axi_dma_wvalid m_axi_dma_wready m_axi_dma_bid[0]
+ m_axi_dma_bid[1] m_axi_dma_bid[2] m_axi_dma_bid[3] m_axi_dma_bid[4] m_axi_dma_bid[5]
+ m_axi_dma_bid[6] m_axi_dma_bid[7] m_axi_dma_bresp[0] m_axi_dma_bresp[1] m_axi_dma_bvalid
+ m_axi_dma_bready m_axi_dma_arid[0] m_axi_dma_arid[1] m_axi_dma_arid[2] m_axi_dma_arid[3]
+ m_axi_dma_arid[4] m_axi_dma_arid[5] m_axi_dma_arid[6] m_axi_dma_arid[7] m_axi_dma_araddr[0]
+ m_axi_dma_araddr[1] m_axi_dma_araddr[2] m_axi_dma_araddr[3] m_axi_dma_araddr[4]
+ m_axi_dma_araddr[5] m_axi_dma_araddr[6] m_axi_dma_araddr[7] m_axi_dma_araddr[8]
+ m_axi_dma_araddr[9] m_axi_dma_araddr[10] m_axi_dma_araddr[11] m_axi_dma_araddr[12]
+ m_axi_dma_araddr[13] m_axi_dma_araddr[14] m_axi_dma_araddr[15] m_axi_dma_araddr[16]
+ m_axi_dma_araddr[17] m_axi_dma_araddr[18] m_axi_dma_araddr[19] m_axi_dma_araddr[20]
+ m_axi_dma_araddr[21] m_axi_dma_araddr[22] m_axi_dma_araddr[23] m_axi_dma_araddr[24]
+ m_axi_dma_araddr[25] m_axi_dma_araddr[26] m_axi_dma_araddr[27] m_axi_dma_araddr[28]
+ m_axi_dma_araddr[29] m_axi_dma_araddr[30] m_axi_dma_araddr[31] m_axi_dma_arlen[0]
+ m_axi_dma_arlen[1] m_axi_dma_arlen[2] m_axi_dma_arlen[3] m_axi_dma_arlen[4] m_axi_dma_arlen[5]
+ m_axi_dma_arlen[6] m_axi_dma_arlen[7] m_axi_dma_arsize[0] m_axi_dma_arsize[1] m_axi_dma_arsize[2]
+ m_axi_dma_arburst[0] m_axi_dma_arburst[1] m_axi_dma_arlock m_axi_dma_arcache[0]
+ m_axi_dma_arcache[1] m_axi_dma_arcache[2] m_axi_dma_arcache[3] m_axi_dma_arprot[0]
+ m_axi_dma_arprot[1] m_axi_dma_arprot[2] m_axi_dma_arvalid m_axi_dma_arready m_axi_dma_rid[0]
+ m_axi_dma_rid[1] m_axi_dma_rid[2] m_axi_dma_rid[3] m_axi_dma_rid[4] m_axi_dma_rid[5]
+ m_axi_dma_rid[6] m_axi_dma_rid[7] m_axi_dma_rdata[0] m_axi_dma_rdata[1] m_axi_dma_rdata[2]
+ m_axi_dma_rdata[3] m_axi_dma_rdata[4] m_axi_dma_rdata[5] m_axi_dma_rdata[6] m_axi_dma_rdata[7]
+ m_axi_dma_rdata[8] m_axi_dma_rdata[9] m_axi_dma_rdata[10] m_axi_dma_rdata[11] m_axi_dma_rdata[12]
+ m_axi_dma_rdata[13] m_axi_dma_rdata[14] m_axi_dma_rdata[15] m_axi_dma_rdata[16]
+ m_axi_dma_rdata[17] m_axi_dma_rdata[18] m_axi_dma_rdata[19] m_axi_dma_rdata[20]
+ m_axi_dma_rdata[21] m_axi_dma_rdata[22] m_axi_dma_rdata[23] m_axi_dma_rdata[24]
+ m_axi_dma_rdata[25] m_axi_dma_rdata[26] m_axi_dma_rdata[27] m_axi_dma_rdata[28]
+ m_axi_dma_rdata[29] m_axi_dma_rdata[30] m_axi_dma_rdata[31] m_axi_dma_rresp[0] m_axi_dma_rresp[1]
+ m_axi_dma_rlast m_axi_dma_rvalid m_axi_dma_rready pmod_io_i[0] pmod_io_i[1] pmod_io_i[2]
+ pmod_io_i[3] pmod_io_i[4] pmod_io_i[5] pmod_io_i[6] pmod_io_i[7] pmod_io_o[0] pmod_io_o[1]
+ pmod_io_o[2] pmod_io_o[3] pmod_io_o[4] pmod_io_o[5] pmod_io_o[6] pmod_io_o[7] pmod_io_oe_o[0]
+ pmod_io_oe_o[1] pmod_io_oe_o[2] pmod_io_oe_o[3] pmod_io_oe_o[4] pmod_io_oe_o[5] pmod_io_oe_o[6]
+ pmod_io_oe_o[7] efpga_cfg_sclk_i efpga_cfg_sdata_i efpga_usr_irq_o[0] efpga_usr_irq_o[1]
+ efpga_usr_irq_o[2] efpga_usr_irq_o[3] efpga_fault_irq_o
.ENDS efpga_subsystem_top
